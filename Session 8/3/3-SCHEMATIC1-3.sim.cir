** Profile: "SCHEMATIC1-3"  [ e:\code\assignments\3rd term\electrical-circuit-lab-fall400\session 8\3\3-schematic1-3.sim ]

** Creating circuit file "3-schematic1-3.sim.cir"
** WARNING: THIS AUTOMATICALLY GENERATED FILE MAY BE OVERWRITTEN BY SUBSEQUENT SIMULATIONS

*Libraries:
* Local Libraries :
* From [PSPICE NETLIST] section of e:\orCad\PSpice\PSpice.ini file:
.lib "nom.lib"

*Analysis directives:
.TRAN  0 3m 0 10u
.PROBE V(*) I(*) W(*) D(*) NOISE(*)
.INC ".\3-SCHEMATIC1.net"

.END
